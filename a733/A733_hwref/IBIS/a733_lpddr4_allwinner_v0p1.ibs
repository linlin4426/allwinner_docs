|/***************************************************************************/
|/*   */
|/* Copyright (c) 2020 Synopsys Inc.All rights reserved   */
|/*   */
|/* This Synopsys IP and all associated documentation are proprietary to   */
|/* Synopsys, Inc. and may only be used pursuant to the terms and conditions*/
|/* of a written license agreement with Synopsys, Inc.   */
|/*   */
|/***************************************************************************/
|/*   */
|/* Product:   SSTL IO IBIS model   */
|/*   */
|/***************************************************************************/
[IBIS Ver] 5.1
[File name] a733_lpddr4_allwinner_v0p1.ibs
[Date] 15 Dec 2020
[File Rev] 0.1
[Notes]
[Disclaimer]
[Component] dwc_ddrphy_txbe
[Manufacturer] allwinner
[Package]
|   typ   min   max
R_pkg   0.29087   0.1204   0.46529
L_pkg   2.797e-9   8.686e-10   4.203e-9
C_pkg   5.404e-13   2.828e-13   8.039e-13
[Pin]   Signal_name   model_name   R_pin   L_pin   C_pin
AT19   SATO   dwc_ddrphy_txbe_PAD   0.31316   2.662e-9   6.213e-13
1AC14   SCA0_A   dwc_ddrphy_txbe_PAD   0.16016   1.419e-9   3.345e-13
1AF12   SCA0_B   dwc_ddrphy_txbe_PAD   0.25623   2.309e-9   5.266e-13
1AE14   SCA1_A   dwc_ddrphy_txbe_PAD   0.22691   2.17e-9   4.725e-13
1AE12   SCA1_B   dwc_ddrphy_txbe_PAD   0.21333   2.118e-9   3.777e-13
1AF16   SCA2_A   dwc_ddrphy_txbe_PAD   0.24164   2.629e-9   4.656e-13
1AE10   SCA2_B   dwc_ddrphy_txbe_PAD   0.22379   1.987e-9   4.832e-13
1AC16   SCA3_A   dwc_ddrphy_txbe_PAD   0.16215   1.363e-9   3.314e-13
1AF10   SCA3_B   dwc_ddrphy_txbe_PAD   0.26524   2.479e-9   5.26e-13
1AB16   SCA4_A   dwc_ddrphy_txbe_PAD   0.13716   1.164e-9   3.546e-13
1AB10   SCA4_B   dwc_ddrphy_txbe_PAD   0.21878   2.157e-9   4.681e-13
1AE16   SCA5_A   dwc_ddrphy_txbe_PAD   0.2164   2.182e-9   4.727e-13
1AC10   SCA5_B   dwc_ddrphy_txbe_PAD   0.17872   1.567e-9   4.187e-13
AU24   SCKE0_A   dwc_ddrphy_txbe_PAD   0.37083   3.617e-9   6.243e-13
AT16   SCKE0_B   dwc_ddrphy_txbe_PAD   0.30103   2.56e-9   5.304e-13
AU21   SCKE1_A   dwc_ddrphy_txbe_PAD   0.34426   2.762e-9   6.773e-13
AU16   SCKE1_B   dwc_ddrphy_txbe_PAD   0.34279   3.17e-9   6.02e-13
AT22   SCKN_A   dwc_ddrphy_txbe_PAD   0.29326   3.337e-9   5.336e-13
AT15   SCKN_B   dwc_ddrphy_txbe_PAD   0.2959   2.842e-9   5.336e-13
AT23   SCKP_A   dwc_ddrphy_txbe_PAD   0.2825   3.321e-9   5.005e-13
AT14   SCKP_B   dwc_ddrphy_txbe_PAD   0.28486   2.862e-9   5.126e-13
AT21   SCS0_A   dwc_ddrphy_txbe_PAD   0.31888   2.524e-9   6.381e-13
AU18   SCS0_B   dwc_ddrphy_txbe_PAD   0.35519   2.944e-9   6.641e-13
1AF14   SCS1_A   dwc_ddrphy_txbe_PAD   0.27205   2.303e-9   5.383e-13
AT18   SCS1_B   dwc_ddrphy_txbe_PAD   0.32545   2.571e-9   6.278e-13
1AF22   SDQ0   dwc_ddrphy_txbe_PAD   0.34372   2.512e-9   6.359e-13
AU31   SDQ1   dwc_ddrphy_txbe_PAD   0.4172   3.314e-9   7.399e-13
1AC20   SDQ2   dwc_ddrphy_txbe_PAD   0.17898   1.74e-9   3.51e-13
1AE22   SDQ3   dwc_ddrphy_txbe_PAD   0.25506   2.814e-9   4.864e-13
AT35   SDQ4   dwc_ddrphy_txbe_PAD   0.43035   3.454e-9   7.294e-13
AU36   SDQ5   dwc_ddrphy_txbe_PAD   0.46529   3.724e-9   8.039e-13
1AB20   SDQ6   dwc_ddrphy_txbe_PAD   0.16219   1.306e-9   3.719e-13
1AE24   SDQ7   dwc_ddrphy_txbe_PAD   0.32334   2.537e-9   5.576e-13
1AF18   SDQ8   dwc_ddrphy_txbe_PAD   0.26618   2.727e-9   4.922e-13
AU25   SDQ9   dwc_ddrphy_txbe_PAD   0.35002   3.243e-9   6.313e-13
1AE18   SDQ10   dwc_ddrphy_txbe_PAD   0.24154   2.33e-9   4.558e-13
AT25   SDQ11   dwc_ddrphy_txbe_PAD   0.31543   2.896e-9   5.788e-13
1AE20   SDQ12   dwc_ddrphy_txbe_PAD   0.27045   2.139e-9   5.017e-13
AT29   SDQ13   dwc_ddrphy_txbe_PAD   0.33437   3.106e-9   6.353e-13
1AC18   SDQ14   dwc_ddrphy_txbe_PAD   0.15675   1.48e-9   4.055e-13
AU30   SDQ15   dwc_ddrphy_txbe_PAD   0.36096   3.821e-9   6.18e-13
1AE8   SDQ16   dwc_ddrphy_txbe_PAD   0.24917   2.077e-9   5.334e-13
AU13   SDQ17   dwc_ddrphy_txbe_PAD   0.31049   3.311e-9   5.461e-13
AU12   SDQ18   dwc_ddrphy_txbe_PAD   0.33252   3.359e-9   5.961e-13
1AF8   SDQ19   dwc_ddrphy_txbe_PAD   0.26496   2.501e-9   5.142e-13
AU9   SDQ20   dwc_ddrphy_txbe_PAD   0.3445   3.559e-9   5.998e-13
1AB8   SDQ21   dwc_ddrphy_txbe_PAD   0.17394   1.617e-9   4.033e-13
AT9   SDQ22   dwc_ddrphy_txbe_PAD   0.32625   3.242e-9   5.674e-13
1AC6   SDQ23   dwc_ddrphy_txbe_PAD   0.19843   1.688e-9   4.03e-13
1AE4   SDQ24   dwc_ddrphy_txbe_PAD   0.25257   2.78e-9   4.726e-13
1AF4   SDQ25   dwc_ddrphy_txbe_PAD   0.29646   3.07e-9   5.563e-13
1AB6   SDQ26   dwc_ddrphy_txbe_PAD   0.14109   1.165e-9   3.832e-13
1AC4   SDQ27   dwc_ddrphy_txbe_PAD   0.20194   2.253e-9   4.032e-13
AT4   SDQ28   dwc_ddrphy_txbe_PAD   0.37881   3.744e-9   5.781e-13
AU4   SDQ29   dwc_ddrphy_txbe_PAD   0.41596   3.993e-9   6.726e-13
1AE2   SDQ30   dwc_ddrphy_txbe_PAD   0.32237   2.709e-9   5.917e-13
AT3   SDQ31   dwc_ddrphy_txbe_PAD   0.38835   3.899e-9   6.068e-13
AT34   SDQM0   dwc_ddrphy_txbe_PAD   0.37497   4.098e-9   5.564e-13
1AF20   SDQM1   dwc_ddrphy_txbe_PAD   0.29306   2.646e-9   5.608e-13
1AC8   SDQM2   dwc_ddrphy_txbe_PAD   0.18979   1.567e-9   3.61e-13
1AF2   SDQM3   dwc_ddrphy_txbe_PAD   0.35468   2.742e-9   7.07e-13
AT31   SDQS0N   dwc_ddrphy_txbe_PAD   0.33263   3.828e-9   5.782e-13
AT32   SDQS0P   dwc_ddrphy_txbe_PAD   0.32452   3.804e-9   5.668e-13
AU27   SDQS1N   dwc_ddrphy_txbe_PAD   0.3372   3.745e-9   6.029e-13
AT27   SDQS1P   dwc_ddrphy_txbe_PAD   0.32594   3.707e-9   5.613e-13
AT11   SDQS2N   dwc_ddrphy_txbe_PAD   0.30361   3.275e-9   5.459e-13
AT10   SDQS2P   dwc_ddrphy_txbe_PAD   0.30462   3.125e-9   5.639e-13
AU7   SDQS3N   dwc_ddrphy_txbe_PAD   0.37285   4.006e-9   6.586e-13
AT7   SDQS3P   dwc_ddrphy_txbe_PAD   0.36219   3.968e-9   6.218e-13
1AB12   SDTO   dwc_ddrphy_txbe_PAD   0.1204   8.686e-10   2.828e-13
1AC12   SRST   dwc_ddrphy_txbe_PAD   0.14983   1.269e-9   3.628e-13
AT20   SZQ   dwc_ddrphy_txbe_PAD   0.33217   2.721e-9   6.669e-13
[Model Selector] dwc_ddrphy_txbe_PAD
txbe_lpd4_25_90   LPDDR4, dwc_ddrphy_txbe_ns, Driver, Z0=90-Ohm at VDDQ/2.5
txbe_lpd4_25_120   LPDDR4, dwc_ddrphy_txbe_ns, Driver, Z0=120-Ohm at VDDQ/2.5
txbe_lpd4_25_180   LPDDR4, dwc_ddrphy_txbe_ns, Driver, Z0=180-Ohm at VDDQ/2.5
txbe_lpd4_25_360   LPDDR4, dwc_ddrphy_txbe_ns, Driver, Z0=360-Ohm at VDDQ/2.5
txbe_lpd4_25_odt60   LPDDR4, dwc_ddrphy_txbe_ns, ODT=60-Ohm at VDDQ/2.5
txbe_lpd4_25_odt80   LPDDR4, dwc_ddrphy_txbe_ns, ODT=80-Ohm at VDDQ/2.5
txbe_lpd4_25_odt120   LPDDR4, dwc_ddrphy_txbe_ns, ODT=120-Ohm at VDDQ/2.5
txbe_lpd4_25_odt240   LPDDR4, dwc_ddrphy_txbe_ns, ODT=240-Ohm at VDDQ/2.5
txbe_lpd4_25_odtoff   LPDDR4, dwc_ddrphy_txbe_ns, ODT=off-Ohm at VDDQ/2.5
txbe_lpd4_3_60   LPDDR4, dwc_ddrphy_txbe_ns, Driver, Z0=60-Ohm at VDDQ/3
txbe_lpd4_3_80   LPDDR4, dwc_ddrphy_txbe_ns, Driver, Z0=80-Ohm at VDDQ/3
txbe_lpd4_3_120   LPDDR4, dwc_ddrphy_txbe_ns, Driver, Z0=120-Ohm at VDDQ/3
txbe_lpd4_3_240   LPDDR4, dwc_ddrphy_txbe_ns, Driver, Z0=240-Ohm at VDDQ/3
txbe_lpd4_3_odt30   LPDDR4, dwc_ddrphy_txbe_ns, ODT=30-Ohm at VDDQ/3
txbe_lpd4_3_odt40   LPDDR4, dwc_ddrphy_txbe_ns, ODT=40-Ohm at VDDQ/3
txbe_lpd4_3_odt60   LPDDR4, dwc_ddrphy_txbe_ns, ODT=60-Ohm at VDDQ/3
txbe_lpd4_3_odt120   LPDDR4, dwc_ddrphy_txbe_ns, ODT=120-Ohm at VDDQ/3
txbe_lpd4_3_odtoff   LPDDR4, dwc_ddrphy_txbe_ns, ODT=off-Ohm at VDDQ/3
txbe_lpd4_25b_90   LPDDR4, dwc_ddrphy_txbe_ns, Boost, Driver, Z0=90-Ohm at VDDQ/2.5
txbe_lpd4_25b_120   LPDDR4, dwc_ddrphy_txbe_ns, Boost, Driver, Z0=120-Ohm at VDDQ/2.5
txbe_lpd4_25b_180   LPDDR4, dwc_ddrphy_txbe_ns, Boost, Driver, Z0=180-Ohm at VDDQ/2.5
txbe_lpd4_25b_360   LPDDR4, dwc_ddrphy_txbe_ns, Boost, Driver, Z0=360-Ohm at VDDQ/2.5
txbe_lpd4_25b_odt60   LPDDR4, dwc_ddrphy_txbe_ns, Boost, ODT=60-Ohm at VDDQ/2.5
txbe_lpd4_25b_odt80   LPDDR4, dwc_ddrphy_txbe_ns, Boost, ODT=80-Ohm at VDDQ/2.5
txbe_lpd4_25b_odt120   LPDDR4, dwc_ddrphy_txbe_ns, Boost, ODT=120-Ohm at VDDQ/2.5
txbe_lpd4_25b_odt240   LPDDR4, dwc_ddrphy_txbe_ns, Boost, ODT=240-Ohm at VDDQ/2.5
txbe_lpd4_25b_odtoff   LPDDR4, dwc_ddrphy_txbe_ns, Boost, ODT=off-Ohm at VDDQ/2.5
txbe_lpd4_3b_60   LPDDR4, dwc_ddrphy_txbe_ns, Boost, Driver, Z0=60-Ohm at VDDQ/3
txbe_lpd4_3b_80   LPDDR4, dwc_ddrphy_txbe_ns, Boost, Driver, Z0=80-Ohm at VDDQ/3
txbe_lpd4_3b_120   LPDDR4, dwc_ddrphy_txbe_ns, Boost, Driver, Z0=120-Ohm at VDDQ/3
txbe_lpd4_3b_240   LPDDR4, dwc_ddrphy_txbe_ns, Boost, Driver, Z0=240-Ohm at VDDQ/3
txbe_lpd4_3b_odt30   LPDDR4, dwc_ddrphy_txbe_ns, Boost, ODT=30-Ohm at VDDQ/3
txbe_lpd4_3b_odt40   LPDDR4, dwc_ddrphy_txbe_ns, Boost, ODT=40-Ohm at VDDQ/3
txbe_lpd4_3b_odt60   LPDDR4, dwc_ddrphy_txbe_ns, Boost, ODT=60-Ohm at VDDQ/3
txbe_lpd4_3b_odt120   LPDDR4, dwc_ddrphy_txbe_ns, Boost, ODT=120-Ohm at VDDQ/3
txbe_lpd4_3b_odtoff   LPDDR4, dwc_ddrphy_txbe_ns, Boost, ODT=off-Ohm at VDDQ/3
| Models and submodels in the file (36): txbe_lpd4_25_120 (I/O), txbe_lpd4_25_180 (I/O), txbe_lpd4_25_360 (I/O), txbe_lpd4_25_90 (I/O), txbe_lpd4_25b_120 (I/O), txbe_lpd4_25b_180 (I/O), txbe_lpd4_25b_360 (I/O), txbe_lpd4_25b_90 (I/O), txbe_lpd4_25b_odt120 (Input), txbe_lpd4_25b_odt240 (Input), txbe_lpd4_25b_odt60 (Input), txbe_lpd4_25b_odt80 (Input), txbe_lpd4_25b_odtoff (Input), txbe_lpd4_25_odt120 (Input), txbe_lpd4_25_odt240 (Input), txbe_lpd4_25_odt60 (Input), txbe_lpd4_25_odt80 (Input), txbe_lpd4_25_odtoff (Input), txbe_lpd4_3_120 (I/O), txbe_lpd4_3_240 (I/O), txbe_lpd4_3_60 (I/O), txbe_lpd4_3_80 (I/O), txbe_lpd4_3b_120 (I/O), txbe_lpd4_3b_240 (I/O), txbe_lpd4_3b_60 (I/O), txbe_lpd4_3b_80 (I/O), txbe_lpd4_3b_odt120 (Input), txbe_lpd4_3b_odt30 (Input), txbe_lpd4_3b_odt40 (Input), txbe_lpd4_3b_odt60 (Input), txbe_lpd4_3b_odtoff (Input), txbe_lpd4_3_odt120 (Input), txbe_lpd4_3_odt30 (Input), txbe_lpd4_3_odt40 (Input), txbe_lpd4_3_odt60 (Input), txbe_lpd4_3_odtoff (Input)
